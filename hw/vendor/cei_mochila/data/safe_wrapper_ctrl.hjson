// Copyright lowRISC contributors.
// Licensed under the Apache License, Version 2.0, see LICENSE for details.
// SPDX-License-Identifier: Apache-2.0
{ name: "safe_wrapper_ctrl",
  clock_primary: "clk_i",
  bus_interfaces: [
    { protocol: "reg_iface", direction: "device" }
  ],
  regwidth: "32",
  registers: [
    { name:     "Safe_configuration",
      desc:     "Configure TMR or DMR",
      swaccess: "rw",
      hwaccess: "hro",
      fields: [
        { bits: "0", name: "Safe_configuration", desc: "Safe_configuration" }
      ]
    },
    { name:     "Safe_mode",
      desc:     "Activate Safe Mode",
      swaccess: "rw",
      hwaccess: "hro",
      fields: [
        { bits: "0", name: "Safe_mode", desc: "Safe_mode" }
      ]
    },
    { name:     "Master_core",
      desc:     "Master Core Configuration",
      swaccess: "rw",
      resval:   "0x1",
      hwaccess: "hro",
      fields: [
        { bits: "2:0", name: "Master_core", desc: "MASTER CORE" }
      ]
    }
   ]
}
