// Copyright lowRISC contributors.
// Licensed under the Apache License, Version 2.0, see LICENSE for details.
// SPDX-License-Identifier: Apache-2.0
{ name: "safe_wrapper_ctrl",
  clock_primary: "clk_i",
  bus_interfaces: [
    { protocol: "reg_iface", direction: "device" }
  ],
  regwidth: "32",
  registers: [
    { name:     "Intc_ack",
      desc:     "ACK Intc Safe_FSM",
      swaccess: "rw",
      hwaccess: "hro",
      fields: [
        { bits: "0", name: "INTC_ACK", desc: "ACK INTC" }
      ]
    },
    { name:     "Master_core",
      desc:     "Master Core Configuration",
      swaccess: "rw",
      hwaccess: "hro",
      fields: [
        { bits: "0", name: "Master_core", desc: "MASTER CORE" }
      ]
    }
   ]
}
